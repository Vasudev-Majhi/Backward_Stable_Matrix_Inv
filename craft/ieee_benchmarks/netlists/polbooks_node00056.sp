* polbooks graph — Political books co-purchase network (105 nodes, 441 edges) — target node 56
.op
VSRC1 1 0 12.000000
VSRC2 53 0 10.000000
VSRC3 105 0 8.000000
R1 1 2 1.000000e+00
R2 1 3 1.000000e+00
R3 1 4 1.000000e+00
R4 1 5 1.000000e+00
R5 1 6 1.000000e+00
R6 1 7 1.000000e+00
R7 2 4 1.000000e+00
R8 2 6 1.000000e+00
R9 2 7 1.000000e+00
R10 3 5 1.000000e+00
R11 3 6 1.000000e+00
R12 3 8 1.000000e+00
R13 4 6 1.000000e+00
R14 4 9 1.000000e+00
R15 4 10 1.000000e+00
R16 4 11 1.000000e+00
R17 4 12 1.000000e+00
R18 4 13 1.000000e+00
R19 4 14 1.000000e+00
R20 4 15 1.000000e+00
R21 4 16 1.000000e+00
R22 4 17 1.000000e+00
R23 4 18 1.000000e+00
R24 4 19 1.000000e+00
R25 4 20 1.000000e+00
R26 4 21 1.000000e+00
R27 4 22 1.000000e+00
R28 4 23 1.000000e+00
R29 4 24 1.000000e+00
R30 4 25 1.000000e+00
R31 4 26 1.000000e+00
R32 4 27 1.000000e+00
R33 4 28 1.000000e+00
R34 5 6 1.000000e+00
R35 5 7 1.000000e+00
R36 5 29 1.000000e+00
R37 5 30 1.000000e+00
R38 5 31 1.000000e+00
R39 5 32 1.000000e+00
R40 6 7 1.000000e+00
R41 6 8 1.000000e+00
R42 7 8 1.000000e+00
R43 7 11 1.000000e+00
R44 7 13 1.000000e+00
R45 7 19 1.000000e+00
R46 7 23 1.000000e+00
R47 7 26 1.000000e+00
R48 7 30 1.000000e+00
R49 8 15 1.000000e+00
R50 8 31 1.000000e+00
R51 8 59 1.000000e+00
R52 8 72 1.000000e+00
R53 8 86 1.000000e+00
R54 9 10 1.000000e+00
R55 9 11 1.000000e+00
R56 9 12 1.000000e+00
R57 9 13 1.000000e+00
R58 9 14 1.000000e+00
R59 9 15 1.000000e+00
R60 9 21 1.000000e+00
R61 9 22 1.000000e+00
R62 9 23 1.000000e+00
R63 9 24 1.000000e+00
R64 9 25 1.000000e+00
R65 9 27 1.000000e+00
R66 9 28 1.000000e+00
R67 9 33 1.000000e+00
R68 9 34 1.000000e+00
R69 9 36 1.000000e+00
R70 9 38 1.000000e+00
R71 9 41 1.000000e+00
R72 9 42 1.000000e+00
R73 9 43 1.000000e+00
R74 9 44 1.000000e+00
R75 9 45 1.000000e+00
R76 9 46 1.000000e+00
R77 9 47 1.000000e+00
R78 10 12 1.000000e+00
R79 10 13 1.000000e+00
R80 10 15 1.000000e+00
R81 10 21 1.000000e+00
R82 10 25 1.000000e+00
R83 10 28 1.000000e+00
R84 10 42 1.000000e+00
R85 10 46 1.000000e+00
R86 10 48 1.000000e+00
R87 10 49 1.000000e+00
R88 10 50 1.000000e+00
R89 10 51 1.000000e+00
R90 10 52 1.000000e+00
R91 10 53 1.000000e+00
R92 11 12 1.000000e+00
R93 11 13 1.000000e+00
R94 11 16 1.000000e+00
R95 11 17 1.000000e+00
R96 11 20 1.000000e+00
R97 11 22 1.000000e+00
R98 11 34 1.000000e+00
R99 11 36 1.000000e+00
R100 11 38 1.000000e+00
R101 11 39 1.000000e+00
R102 11 40 1.000000e+00
R103 11 56 1.000000e+00
R104 12 13 1.000000e+00
R105 12 14 1.000000e+00
R106 12 15 1.000000e+00
R107 12 18 1.000000e+00
R108 12 21 1.000000e+00
R109 12 22 1.000000e+00
R110 12 23 1.000000e+00
R111 12 27 1.000000e+00
R112 12 28 1.000000e+00
R113 12 30 1.000000e+00
R114 12 46 1.000000e+00
R115 12 48 1.000000e+00
R116 12 51 1.000000e+00
R117 12 57 1.000000e+00
R118 13 14 1.000000e+00
R119 13 15 1.000000e+00
R120 13 16 1.000000e+00
R121 13 18 1.000000e+00
R122 13 19 1.000000e+00
R123 13 24 1.000000e+00
R124 13 25 1.000000e+00
R125 13 33 1.000000e+00
R126 13 34 1.000000e+00
R127 13 37 1.000000e+00
R128 13 39 1.000000e+00
R129 13 40 1.000000e+00
R130 13 41 1.000000e+00
R131 13 42 1.000000e+00
R132 13 45 1.000000e+00
R133 13 47 1.000000e+00
R134 13 48 1.000000e+00
R135 13 55 1.000000e+00
R136 13 56 1.000000e+00
R137 14 18 1.000000e+00
R138 14 30 1.000000e+00
R139 14 33 1.000000e+00
R140 14 41 1.000000e+00
R141 14 43 1.000000e+00
R142 14 44 1.000000e+00
R143 14 45 1.000000e+00
R144 14 48 1.000000e+00
R145 14 58 1.000000e+00
R146 15 26 1.000000e+00
R147 15 27 1.000000e+00
R148 15 59 1.000000e+00
R149 16 17 1.000000e+00
R150 16 56 1.000000e+00
R151 18 48 1.000000e+00
R152 20 56 1.000000e+00
R153 20 57 1.000000e+00
R154 20 78 1.000000e+00
R155 21 25 1.000000e+00
R156 21 41 1.000000e+00
R157 21 49 1.000000e+00
R158 21 50 1.000000e+00
R159 21 54 1.000000e+00
R160 21 58 1.000000e+00
R161 22 24 1.000000e+00
R162 23 26 1.000000e+00
R163 23 41 1.000000e+00
R164 23 53 1.000000e+00
R165 24 28 1.000000e+00
R166 24 33 1.000000e+00
R167 24 34 1.000000e+00
R168 24 48 1.000000e+00
R169 24 55 1.000000e+00
R170 25 27 1.000000e+00
R171 25 41 1.000000e+00
R172 25 48 1.000000e+00
R173 25 54 1.000000e+00
R174 26 41 1.000000e+00
R175 27 41 1.000000e+00
R176 27 46 1.000000e+00
R177 27 48 1.000000e+00
R178 27 54 1.000000e+00
R179 28 41 1.000000e+00
R180 28 42 1.000000e+00
R181 28 48 1.000000e+00
R182 28 55 1.000000e+00
R183 29 67 1.000000e+00
R184 29 73 1.000000e+00
R185 31 32 1.000000e+00
R186 31 59 1.000000e+00
R187 31 67 1.000000e+00
R188 31 68 1.000000e+00
R189 31 71 1.000000e+00
R190 31 74 1.000000e+00
R191 31 75 1.000000e+00
R192 31 76 1.000000e+00
R193 31 77 1.000000e+00
R194 31 78 1.000000e+00
R195 31 80 1.000000e+00
R196 31 81 1.000000e+00
R197 31 83 1.000000e+00
R198 31 84 1.000000e+00
R199 31 85 1.000000e+00
R200 31 87 1.000000e+00
R201 31 94 1.000000e+00
R202 31 100 1.000000e+00
R203 32 50 1.000000e+00
R204 32 74 1.000000e+00
R205 32 75 1.000000e+00
R206 32 76 1.000000e+00
R207 32 77 1.000000e+00
R208 32 78 1.000000e+00
R209 32 79 1.000000e+00
R210 32 83 1.000000e+00
R211 32 92 1.000000e+00
R212 33 34 1.000000e+00
R213 34 38 1.000000e+00
R214 34 39 1.000000e+00
R215 34 40 1.000000e+00
R216 34 48 1.000000e+00
R217 35 36 1.000000e+00
R218 35 37 1.000000e+00
R219 35 38 1.000000e+00
R220 35 39 1.000000e+00
R221 35 40 1.000000e+00
R222 36 37 1.000000e+00
R223 36 38 1.000000e+00
R224 36 39 1.000000e+00
R225 36 40 1.000000e+00
R226 36 41 1.000000e+00
R227 36 44 1.000000e+00
R228 36 45 1.000000e+00
R229 37 42 1.000000e+00
R230 37 48 1.000000e+00
R231 38 39 1.000000e+00
R232 38 48 1.000000e+00
R233 39 40 1.000000e+00
R234 40 41 1.000000e+00
R235 40 43 1.000000e+00
R236 41 42 1.000000e+00
R237 41 43 1.000000e+00
R238 41 45 1.000000e+00
R239 41 46 1.000000e+00
R240 41 48 1.000000e+00
R241 41 54 1.000000e+00
R242 41 55 1.000000e+00
R243 42 48 1.000000e+00
R244 42 55 1.000000e+00
R245 43 44 1.000000e+00
R246 43 48 1.000000e+00
R247 44 57 1.000000e+00
R248 46 48 1.000000e+00
R249 47 48 1.000000e+00
R250 47 103 1.000000e+00
R251 48 55 1.000000e+00
R252 49 50 1.000000e+00
R253 49 58 1.000000e+00
R254 50 58 1.000000e+00
R255 50 59 1.000000e+00
R256 50 73 1.000000e+00
R257 50 77 1.000000e+00
R258 51 59 1.000000e+00
R259 52 53 1.000000e+00
R260 52 59 1.000000e+00
R261 52 65 1.000000e+00
R262 52 66 1.000000e+00
R263 52 70 1.000000e+00
R264 53 59 1.000000e+00
R265 53 65 1.000000e+00
R266 54 77 1.000000e+00
R267 57 58 1.000000e+00
R268 59 65 1.000000e+00
R269 59 66 1.000000e+00
R270 59 69 1.000000e+00
R271 59 70 1.000000e+00
R272 59 78 1.000000e+00
R273 59 86 1.000000e+00
R274 60 61 1.000000e+00
R275 60 62 1.000000e+00
R276 60 63 1.000000e+00
R277 60 64 1.000000e+00
R278 60 100 1.000000e+00
R279 61 63 1.000000e+00
R280 61 64 1.000000e+00
R281 61 85 1.000000e+00
R282 61 87 1.000000e+00
R283 61 100 1.000000e+00
R284 62 87 1.000000e+00
R285 62 96 1.000000e+00
R286 62 102 1.000000e+00
R287 63 64 1.000000e+00
R288 63 85 1.000000e+00
R289 63 100 1.000000e+00
R290 63 101 1.000000e+00
R291 64 100 1.000000e+00
R292 65 66 1.000000e+00
R293 65 67 1.000000e+00
R294 65 68 1.000000e+00
R295 65 69 1.000000e+00
R296 65 70 1.000000e+00
R297 65 71 1.000000e+00
R298 66 68 1.000000e+00
R299 66 69 1.000000e+00
R300 66 70 1.000000e+00
R301 66 86 1.000000e+00
R302 67 68 1.000000e+00
R303 67 71 1.000000e+00
R304 67 73 1.000000e+00
R305 67 74 1.000000e+00
R306 67 75 1.000000e+00
R307 67 77 1.000000e+00
R308 67 81 1.000000e+00
R309 67 85 1.000000e+00
R310 67 86 1.000000e+00
R311 67 87 1.000000e+00
R312 67 89 1.000000e+00
R313 67 90 1.000000e+00
R314 67 91 1.000000e+00
R315 67 94 1.000000e+00
R316 67 97 1.000000e+00
R317 67 98 1.000000e+00
R318 67 100 1.000000e+00
R319 67 101 1.000000e+00
R320 68 104 1.000000e+00
R321 68 105 1.000000e+00
R322 69 72 1.000000e+00
R323 70 105 1.000000e+00
R324 71 72 1.000000e+00
R325 71 73 1.000000e+00
R326 71 76 1.000000e+00
R327 71 91 1.000000e+00
R328 72 73 1.000000e+00
R329 72 74 1.000000e+00
R330 72 75 1.000000e+00
R331 72 76 1.000000e+00
R332 72 77 1.000000e+00
R333 72 78 1.000000e+00
R334 72 79 1.000000e+00
R335 72 80 1.000000e+00
R336 72 81 1.000000e+00
R337 72 82 1.000000e+00
R338 72 83 1.000000e+00
R339 72 84 1.000000e+00
R340 73 74 1.000000e+00
R341 73 75 1.000000e+00
R342 73 76 1.000000e+00
R343 73 77 1.000000e+00
R344 73 79 1.000000e+00
R345 73 80 1.000000e+00
R346 73 81 1.000000e+00
R347 73 83 1.000000e+00
R348 73 85 1.000000e+00
R349 73 86 1.000000e+00
R350 73 87 1.000000e+00
R351 73 88 1.000000e+00
R352 73 89 1.000000e+00
R353 73 90 1.000000e+00
R354 73 91 1.000000e+00
R355 73 92 1.000000e+00
R356 73 93 1.000000e+00
R357 74 75 1.000000e+00
R358 74 76 1.000000e+00
R359 74 83 1.000000e+00
R360 74 84 1.000000e+00
R361 74 85 1.000000e+00
R362 74 87 1.000000e+00
R363 74 90 1.000000e+00
R364 74 93 1.000000e+00
R365 74 94 1.000000e+00
R366 74 95 1.000000e+00
R367 74 96 1.000000e+00
R368 74 97 1.000000e+00
R369 74 98 1.000000e+00
R370 74 99 1.000000e+00
R371 74 100 1.000000e+00
R372 74 101 1.000000e+00
R373 75 76 1.000000e+00
R374 75 79 1.000000e+00
R375 75 80 1.000000e+00
R376 75 83 1.000000e+00
R377 75 85 1.000000e+00
R378 75 88 1.000000e+00
R379 75 89 1.000000e+00
R380 75 92 1.000000e+00
R381 75 99 1.000000e+00
R382 75 100 1.000000e+00
R383 76 77 1.000000e+00
R384 76 78 1.000000e+00
R385 76 79 1.000000e+00
R386 76 80 1.000000e+00
R387 76 83 1.000000e+00
R388 76 84 1.000000e+00
R389 76 85 1.000000e+00
R390 76 92 1.000000e+00
R391 76 93 1.000000e+00
R392 77 78 1.000000e+00
R393 77 83 1.000000e+00
R394 77 84 1.000000e+00
R395 77 85 1.000000e+00
R396 77 87 1.000000e+00
R397 80 85 1.000000e+00
R398 80 92 1.000000e+00
R399 80 101 1.000000e+00
R400 82 85 1.000000e+00
R401 82 87 1.000000e+00
R402 82 98 1.000000e+00
R403 83 85 1.000000e+00
R404 84 85 1.000000e+00
R405 84 88 1.000000e+00
R406 84 101 1.000000e+00
R407 85 87 1.000000e+00
R408 85 88 1.000000e+00
R409 85 89 1.000000e+00
R410 85 90 1.000000e+00
R411 85 95 1.000000e+00
R412 85 97 1.000000e+00
R413 85 98 1.000000e+00
R414 85 100 1.000000e+00
R415 85 101 1.000000e+00
R416 85 102 1.000000e+00
R417 87 90 1.000000e+00
R418 87 94 1.000000e+00
R419 87 98 1.000000e+00
R420 87 101 1.000000e+00
R421 87 102 1.000000e+00
R422 88 99 1.000000e+00
R423 89 90 1.000000e+00
R424 91 92 1.000000e+00
R425 91 100 1.000000e+00
R426 92 99 1.000000e+00
R427 92 101 1.000000e+00
R428 94 95 1.000000e+00
R429 94 100 1.000000e+00
R430 94 103 1.000000e+00
R431 95 96 1.000000e+00
R432 95 97 1.000000e+00
R433 95 102 1.000000e+00
R434 95 103 1.000000e+00
R435 96 103 1.000000e+00
R436 97 98 1.000000e+00
R437 97 101 1.000000e+00
R438 99 101 1.000000e+00
R439 100 101 1.000000e+00
R440 101 102 1.000000e+00
R441 104 105 1.000000e+00
.end
