* dolphins graph — Bottlenose dolphin social network (62 nodes, 159 edges) — target node 3
.op
VSRC1 1 0 12.000000
VSRC2 32 0 10.000000
VSRC3 62 0 8.000000
R1 1 11 1.000000e+00
R2 1 15 1.000000e+00
R3 1 16 1.000000e+00
R4 1 41 1.000000e+00
R5 1 43 1.000000e+00
R6 1 48 1.000000e+00
R7 2 18 1.000000e+00
R8 2 20 1.000000e+00
R9 2 27 1.000000e+00
R10 2 28 1.000000e+00
R11 2 29 1.000000e+00
R12 2 37 1.000000e+00
R13 2 42 1.000000e+00
R14 2 55 1.000000e+00
R15 3 19 1.000000e+00
R16 3 23 1.000000e+00
R17 4 21 1.000000e+00
R18 4 38 1.000000e+00
R19 4 46 1.000000e+00
R20 5 13 1.000000e+00
R21 5 39 1.000000e+00
R22 5 44 1.000000e+00
R23 6 38 1.000000e+00
R24 6 46 1.000000e+00
R25 6 52 1.000000e+00
R26 7 14 1.000000e+00
R27 7 58 1.000000e+00
R28 8 14 1.000000e+00
R29 8 45 1.000000e+00
R30 8 54 1.000000e+00
R31 8 58 1.000000e+00
R32 9 30 1.000000e+00
R33 9 42 1.000000e+00
R34 9 61 1.000000e+00
R35 10 18 1.000000e+00
R36 10 14 1.000000e+00
R37 10 21 1.000000e+00
R38 10 36 1.000000e+00
R39 10 58 1.000000e+00
R40 11 43 1.000000e+00
R41 11 48 1.000000e+00
R42 12 22 1.000000e+00
R43 12 23 1.000000e+00
R44 12 32 1.000000e+00
R45 12 35 1.000000e+00
R46 12 37 1.000000e+00
R47 12 47 1.000000e+00
R48 12 53 1.000000e+00
R49 12 56 1.000000e+00
R50 13 39 1.000000e+00
R51 13 44 1.000000e+00
R52 14 58 1.000000e+00
R53 15 16 1.000000e+00
R54 15 41 1.000000e+00
R55 15 48 1.000000e+00
R56 16 41 1.000000e+00
R57 16 43 1.000000e+00
R58 16 48 1.000000e+00
R59 17 27 1.000000e+00
R60 18 36 1.000000e+00
R61 18 58 1.000000e+00
R62 19 23 1.000000e+00
R63 19 59 1.000000e+00
R64 20 28 1.000000e+00
R65 20 29 1.000000e+00
R66 20 37 1.000000e+00
R67 20 42 1.000000e+00
R68 20 55 1.000000e+00
R69 21 36 1.000000e+00
R70 21 38 1.000000e+00
R71 21 46 1.000000e+00
R72 22 53 1.000000e+00
R73 22 56 1.000000e+00
R74 23 59 1.000000e+00
R75 24 40 1.000000e+00
R76 24 54 1.000000e+00
R77 24 62 1.000000e+00
R78 25 40 1.000000e+00
R79 25 45 1.000000e+00
R80 25 54 1.000000e+00
R81 26 31 1.000000e+00
R82 26 35 1.000000e+00
R83 26 38 1.000000e+00
R84 26 41 1.000000e+00
R85 26 48 1.000000e+00
R86 26 56 1.000000e+00
R87 27 28 1.000000e+00
R88 27 29 1.000000e+00
R89 27 37 1.000000e+00
R90 27 42 1.000000e+00
R91 27 55 1.000000e+00
R92 28 29 1.000000e+00
R93 28 37 1.000000e+00
R94 28 42 1.000000e+00
R95 28 55 1.000000e+00
R96 29 37 1.000000e+00
R97 29 42 1.000000e+00
R98 29 55 1.000000e+00
R99 30 42 1.000000e+00
R100 30 61 1.000000e+00
R101 31 35 1.000000e+00
R102 31 38 1.000000e+00
R103 31 46 1.000000e+00
R104 31 56 1.000000e+00
R105 32 47 1.000000e+00
R106 32 53 1.000000e+00
R107 32 56 1.000000e+00
R108 33 37 1.000000e+00
R109 33 42 1.000000e+00
R110 33 55 1.000000e+00
R111 34 38 1.000000e+00
R112 34 41 1.000000e+00
R113 34 46 1.000000e+00
R114 34 51 1.000000e+00
R115 34 56 1.000000e+00
R116 35 56 1.000000e+00
R117 36 58 1.000000e+00
R118 37 42 1.000000e+00
R119 37 55 1.000000e+00
R120 38 46 1.000000e+00
R121 39 44 1.000000e+00
R122 40 45 1.000000e+00
R123 40 54 1.000000e+00
R124 40 62 1.000000e+00
R125 41 48 1.000000e+00
R126 42 55 1.000000e+00
R127 43 48 1.000000e+00
R128 44 59 1.000000e+00
R129 45 54 1.000000e+00
R130 47 53 1.000000e+00
R131 47 56 1.000000e+00
R132 48 56 1.000000e+00
R133 49 51 1.000000e+00
R134 49 56 1.000000e+00
R135 50 56 1.000000e+00
R136 51 56 1.000000e+00
R137 52 62 1.000000e+00
R138 53 56 1.000000e+00
R139 57 58 1.000000e+00
R140 59 60 1.000000e+00
R141 59 62 1.000000e+00
R142 61 62 1.000000e+00
.end
