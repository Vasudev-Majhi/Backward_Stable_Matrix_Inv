* lesmis graph — Les Miserables character co-appearance weighted graph (77 nodes, 254 edges) — target node 42
.op
VSRC1 1 0 12.000000
VSRC2 28 0 10.000000
VSRC3 54 0 8.000000
R1 1 2 1.000000e+00
R2 1 3 1.250000e-01
R3 1 4 1.000000e-01
R4 1 5 1.000000e+00
R5 1 6 1.000000e+00
R6 1 7 1.000000e+00
R7 1 8 1.000000e+00
R8 1 9 5.000000e-01
R9 1 10 1.000000e+00
R10 2 3 1.666667e-01
R11 2 4 1.000000e+00
R12 3 4 3.333333e-01
R13 3 5 5.000000e-01
R14 3 6 1.000000e+00
R15 3 10 1.000000e+00
R16 3 11 1.000000e+00
R17 3 12 5.000000e-01
R18 3 13 1.000000e+00
R19 3 14 1.000000e+00
R20 3 16 1.000000e+00
R21 3 17 1.000000e+00
R22 3 18 1.000000e+00
R23 3 19 1.000000e+00
R24 3 20 5.000000e-01
R25 3 21 1.000000e+00
R26 3 22 1.000000e+00
R27 3 23 1.000000e+00
R28 3 24 5.000000e-01
R29 3 25 1.000000e+00
R30 3 26 1.000000e+00
R31 3 27 1.000000e+00
R32 3 28 1.000000e+00
R33 3 29 1.000000e+00
R34 3 30 1.000000e+00
R35 3 31 1.000000e+00
R36 3 32 1.000000e+00
R37 3 33 1.000000e+00
R38 3 34 1.000000e+00
R39 3 35 1.000000e+00
R40 3 36 5.000000e-01
R41 3 37 1.000000e+00
R42 3 38 1.000000e+00
R43 3 39 2.500000e-01
R44 3 40 1.000000e+00
R45 3 41 1.000000e+00
R46 3 42 5.000000e-01
R47 3 43 2.500000e-01
R48 3 44 1.000000e+00
R49 3 45 1.000000e+00
R50 3 46 1.000000e+00
R51 3 47 1.666667e-01
R52 4 6 1.000000e+00
R53 4 7 1.000000e+00
R54 4 10 1.000000e+00
R55 4 15 1.000000e+00
R56 4 47 1.000000e+00
R57 5 6 1.000000e+00
R58 5 7 1.000000e+00
R59 5 8 1.000000e+00
R60 5 9 1.000000e+00
R61 5 10 1.000000e+00
R62 5 11 1.000000e+00
R63 5 12 1.000000e+00
R64 5 13 1.000000e+00
R65 5 14 1.000000e+00
R66 5 15 1.000000e+00
R67 5 16 2.500000e-01
R68 5 17 2.500000e-01
R69 5 18 1.000000e+00
R70 5 19 5.000000e-01
R71 5 20 3.333333e-01
R72 6 7 3.333333e-01
R73 6 8 1.000000e+00
R74 6 9 1.000000e+00
R75 6 10 1.000000e+00
R76 7 8 1.000000e+00
R77 7 9 1.000000e+00
R78 7 10 1.000000e+00
R79 8 9 5.000000e-01
R80 8 10 1.000000e+00
R81 9 10 5.000000e-01
R82 11 12 2.500000e-01
R83 11 13 2.500000e-01
R84 12 13 5.882353e-02
R85 13 14 2.000000e-01
R86 13 15 5.000000e-01
R87 14 15 1.000000e+00
R88 16 17 2.000000e-01
R89 16 18 3.333333e-01
R90 16 19 1.000000e+00
R91 16 20 1.666667e-01
R92 16 21 5.000000e-01
R93 16 22 1.000000e+00
R94 16 23 1.000000e+00
R95 16 47 5.000000e-01
R96 17 18 3.333333e-01
R97 17 19 1.000000e+00
R98 17 20 1.666667e-01
R99 17 21 5.000000e-01
R100 17 22 1.000000e+00
R101 17 23 1.000000e+00
R102 17 47 5.000000e-01
R103 18 19 1.000000e+00
R104 18 20 1.000000e+00
R105 18 47 1.000000e+00
R106 19 20 5.000000e-01
R107 19 47 1.000000e+00
R108 20 21 5.000000e-01
R109 20 22 5.000000e-01
R110 20 23 5.000000e-01
R111 20 24 1.000000e+00
R112 20 25 1.000000e+00
R113 20 26 1.000000e+00
R114 20 47 2.500000e-01
R115 21 47 1.000000e+00
R116 22 23 3.333333e-01
R117 22 47 1.000000e+00
R118 23 47 1.000000e+00
R119 24 25 2.500000e-01
R120 24 26 5.000000e-01
R121 24 27 1.000000e+00
R122 24 28 1.000000e+00
R123 24 29 1.000000e+00
R124 24 30 1.000000e+00
R125 25 26 5.000000e-01
R126 25 27 1.000000e+00
R127 25 28 1.000000e+00
R128 25 29 1.000000e+00
R129 25 30 1.000000e+00
R130 26 27 1.000000e+00
R131 26 28 1.000000e+00
R132 26 29 1.000000e+00
R133 26 30 1.000000e+00
R134 27 28 1.000000e+00
R135 27 29 1.000000e+00
R136 27 30 1.000000e+00
R137 27 31 1.000000e+00
R138 28 29 1.000000e+00
R139 28 30 1.000000e+00
R140 28 31 1.000000e+00
R141 29 30 1.000000e+00
R142 29 31 5.000000e-01
R143 30 31 1.000000e+00
R144 31 32 5.000000e-01
R145 31 33 5.000000e-01
R146 31 34 5.000000e-01
R147 32 33 3.333333e-01
R148 32 34 3.333333e-01
R149 33 34 2.500000e-01
R150 35 36 5.000000e-01
R151 35 37 5.000000e-01
R152 36 37 5.000000e-01
R153 36 38 5.000000e-01
R154 36 39 1.666667e-01
R155 37 38 5.000000e-01
R156 37 39 1.666667e-01
R157 38 39 1.666667e-01
R158 40 41 1.666667e-01
R159 41 42 1.000000e+00
R160 41 43 3.333333e-01
R161 42 43 1.000000e+00
R162 44 45 5.000000e-01
R163 44 46 5.000000e-01
R164 44 47 5.000000e-01
R165 45 46 1.666667e-01
R166 45 47 5.000000e-01
R167 46 47 5.000000e-01
R168 47 48 5.000000e-01
R169 47 49 5.000000e-01
R170 47 50 5.000000e-01
R171 47 51 5.000000e-01
R172 47 52 5.000000e-01
R173 47 53 5.000000e-01
R174 47 54 5.000000e-01
R175 48 49 1.000000e+00
R176 48 50 1.000000e+00
R177 48 51 1.000000e+00
R178 48 52 1.000000e+00
R179 48 53 5.000000e-01
R180 48 54 1.000000e+00
R181 49 50 1.000000e+00
R182 49 51 1.000000e+00
R183 49 52 1.000000e+00
R184 49 53 1.000000e+00
R185 49 54 1.000000e+00
R186 50 51 1.000000e+00
R187 50 52 1.000000e+00
R188 50 53 5.000000e-01
R189 50 54 1.000000e+00
R190 51 52 1.000000e+00
R191 51 53 5.000000e-01
R192 51 54 1.000000e+00
R193 52 53 5.000000e-01
R194 52 54 1.000000e+00
R195 53 54 5.000000e-01
.end
