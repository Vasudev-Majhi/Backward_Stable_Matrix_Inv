* bcspwr03 IEEE 118-bus network topology — target node 113
.op
VSRC1 1 0 12.000000
VSRC2 59 0 10.000000
VSRC3 118 0 8.000000
R1 1 2 1.000000e+00
R2 1 3 1.000000e+00
R3 4 5 1.000000e+00
R4 3 5 1.000000e+00
R5 5 6 1.000000e+00
R6 6 7 1.000000e+00
R7 8 9 1.000000e+00
R8 8 5 1.000000e+00
R9 9 10 1.000000e+00
R10 4 11 1.000000e+00
R11 5 11 1.000000e+00
R12 11 12 1.000000e+00
R13 2 12 1.000000e+00
R14 3 12 1.000000e+00
R15 7 12 1.000000e+00
R16 11 13 1.000000e+00
R17 12 14 1.000000e+00
R18 13 15 1.000000e+00
R19 14 15 1.000000e+00
R20 12 16 1.000000e+00
R21 15 17 1.000000e+00
R22 16 17 1.000000e+00
R23 17 18 1.000000e+00
R24 18 19 1.000000e+00
R25 19 20 1.000000e+00
R26 15 19 1.000000e+00
R27 20 21 1.000000e+00
R28 21 22 1.000000e+00
R29 22 23 1.000000e+00
R30 23 24 1.000000e+00
R31 23 25 1.000000e+00
R32 26 25 1.000000e+00
R33 25 27 1.000000e+00
R34 27 28 1.000000e+00
R35 28 29 1.000000e+00
R36 30 17 1.000000e+00
R37 8 30 1.000000e+00
R38 26 30 1.000000e+00
R39 17 31 1.000000e+00
R40 29 31 1.000000e+00
R41 23 32 1.000000e+00
R42 31 32 1.000000e+00
R43 27 32 1.000000e+00
R44 15 33 1.000000e+00
R45 19 34 1.000000e+00
R46 35 36 1.000000e+00
R47 35 37 1.000000e+00
R48 33 37 1.000000e+00
R49 34 36 1.000000e+00
R50 34 37 1.000000e+00
R51 38 37 1.000000e+00
R52 37 39 1.000000e+00
R53 37 40 1.000000e+00
R54 30 38 1.000000e+00
R55 39 40 1.000000e+00
R56 40 41 1.000000e+00
R57 40 42 1.000000e+00
R58 41 42 1.000000e+00
R59 43 44 1.000000e+00
R60 34 43 1.000000e+00
R61 44 45 1.000000e+00
R62 45 46 1.000000e+00
R63 46 47 1.000000e+00
R64 46 48 1.000000e+00
R65 47 49 1.000000e+00
R66 42 49 1.000000e+00
R67 42 49 1.000000e+00
R68 45 49 1.000000e+00
R69 48 49 1.000000e+00
R70 49 50 1.000000e+00
R71 49 51 1.000000e+00
R72 51 52 1.000000e+00
R73 52 53 1.000000e+00
R74 53 54 1.000000e+00
R75 49 54 1.000000e+00
R76 49 54 1.000000e+00
R77 54 55 1.000000e+00
R78 54 56 1.000000e+00
R79 55 56 1.000000e+00
R80 56 57 1.000000e+00
R81 50 57 1.000000e+00
R82 56 58 1.000000e+00
R83 51 58 1.000000e+00
R84 54 59 1.000000e+00
R85 56 59 1.000000e+00
R86 56 59 1.000000e+00
R87 55 59 1.000000e+00
R88 59 60 1.000000e+00
R89 59 61 1.000000e+00
R90 60 61 1.000000e+00
R91 60 62 1.000000e+00
R92 61 62 1.000000e+00
R93 63 59 1.000000e+00
R94 63 64 1.000000e+00
R95 64 61 1.000000e+00
R96 38 65 1.000000e+00
R97 64 65 1.000000e+00
R98 49 66 1.000000e+00
R99 49 66 1.000000e+00
R100 62 66 1.000000e+00
R101 62 67 1.000000e+00
R102 65 66 1.000000e+00
R103 66 67 1.000000e+00
R104 65 68 1.000000e+00
R105 47 69 1.000000e+00
R106 49 69 1.000000e+00
R107 68 69 1.000000e+00
R108 69 70 1.000000e+00
R109 24 70 1.000000e+00
R110 70 71 1.000000e+00
R111 24 72 1.000000e+00
R112 71 72 1.000000e+00
R113 71 73 1.000000e+00
R114 70 74 1.000000e+00
R115 70 75 1.000000e+00
R116 69 75 1.000000e+00
R117 74 75 1.000000e+00
R118 76 77 1.000000e+00
R119 69 77 1.000000e+00
R120 75 77 1.000000e+00
R121 77 78 1.000000e+00
R122 78 79 1.000000e+00
R123 77 80 1.000000e+00
R124 77 80 1.000000e+00
R125 79 80 1.000000e+00
R126 68 81 1.000000e+00
R127 81 80 1.000000e+00
R128 77 82 1.000000e+00
R129 82 83 1.000000e+00
R130 83 84 1.000000e+00
R131 83 85 1.000000e+00
R132 84 85 1.000000e+00
R133 85 86 1.000000e+00
R134 86 87 1.000000e+00
R135 85 88 1.000000e+00
R136 85 89 1.000000e+00
R137 88 89 1.000000e+00
R138 89 90 1.000000e+00
R139 89 90 1.000000e+00
R140 90 91 1.000000e+00
R141 89 92 1.000000e+00
R142 89 92 1.000000e+00
R143 91 92 1.000000e+00
R144 92 93 1.000000e+00
R145 92 94 1.000000e+00
R146 93 94 1.000000e+00
R147 94 95 1.000000e+00
R148 80 96 1.000000e+00
R149 82 96 1.000000e+00
R150 94 96 1.000000e+00
R151 80 97 1.000000e+00
R152 80 98 1.000000e+00
R153 80 99 1.000000e+00
R154 92 100 1.000000e+00
R155 94 100 1.000000e+00
R156 95 96 1.000000e+00
R157 96 97 1.000000e+00
R158 98 100 1.000000e+00
R159 99 100 1.000000e+00
R160 100 101 1.000000e+00
R161 92 102 1.000000e+00
R162 101 102 1.000000e+00
R163 100 103 1.000000e+00
R164 100 104 1.000000e+00
R165 103 104 1.000000e+00
R166 103 105 1.000000e+00
R167 100 106 1.000000e+00
R168 104 105 1.000000e+00
R169 105 106 1.000000e+00
R170 105 107 1.000000e+00
R171 105 108 1.000000e+00
R172 106 107 1.000000e+00
R173 108 109 1.000000e+00
R174 103 110 1.000000e+00
R175 109 110 1.000000e+00
R176 110 111 1.000000e+00
R177 110 112 1.000000e+00
R178 17 113 1.000000e+00
R179 32 113 1.000000e+00
R180 32 114 1.000000e+00
R181 27 115 1.000000e+00
R182 114 115 1.000000e+00
R183 68 116 1.000000e+00
R184 12 117 1.000000e+00
R185 75 118 1.000000e+00
R186 76 118 1.000000e+00
.end
