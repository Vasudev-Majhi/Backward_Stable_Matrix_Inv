* karate graph — Zachary Karate Club social network (34 nodes, 78 edges) — target node 28
.op
VSRC1 1 0 12.000000
VSRC2 18 0 10.000000
VSRC3 34 0 8.000000
R1 1 2 1.000000e+00
R2 1 3 1.000000e+00
R3 1 4 1.000000e+00
R4 1 5 1.000000e+00
R5 1 6 1.000000e+00
R6 1 7 1.000000e+00
R7 1 8 1.000000e+00
R8 1 9 1.000000e+00
R9 1 11 1.000000e+00
R10 1 12 1.000000e+00
R11 1 13 1.000000e+00
R12 1 14 1.000000e+00
R13 1 18 1.000000e+00
R14 1 20 1.000000e+00
R15 1 22 1.000000e+00
R16 1 32 1.000000e+00
R17 2 3 1.000000e+00
R18 2 4 1.000000e+00
R19 2 8 1.000000e+00
R20 2 14 1.000000e+00
R21 2 18 1.000000e+00
R22 2 20 1.000000e+00
R23 2 22 1.000000e+00
R24 2 31 1.000000e+00
R25 3 4 1.000000e+00
R26 3 8 1.000000e+00
R27 3 9 1.000000e+00
R28 3 10 1.000000e+00
R29 3 14 1.000000e+00
R30 3 28 1.000000e+00
R31 3 29 1.000000e+00
R32 3 33 1.000000e+00
R33 4 8 1.000000e+00
R34 4 13 1.000000e+00
R35 4 14 1.000000e+00
R36 5 7 1.000000e+00
R37 5 11 1.000000e+00
R38 6 7 1.000000e+00
R39 6 11 1.000000e+00
R40 6 17 1.000000e+00
R41 7 17 1.000000e+00
R42 9 31 1.000000e+00
R43 9 33 1.000000e+00
R44 9 34 1.000000e+00
R45 10 34 1.000000e+00
R46 14 34 1.000000e+00
R47 15 33 1.000000e+00
R48 15 34 1.000000e+00
R49 16 33 1.000000e+00
R50 16 34 1.000000e+00
R51 19 33 1.000000e+00
R52 19 34 1.000000e+00
R53 20 34 1.000000e+00
R54 21 33 1.000000e+00
R55 21 34 1.000000e+00
R56 23 33 1.000000e+00
R57 23 34 1.000000e+00
R58 24 26 1.000000e+00
R59 24 28 1.000000e+00
R60 24 30 1.000000e+00
R61 24 33 1.000000e+00
R62 24 34 1.000000e+00
R63 25 26 1.000000e+00
R64 25 28 1.000000e+00
R65 25 32 1.000000e+00
R66 26 32 1.000000e+00
R67 27 30 1.000000e+00
R68 27 34 1.000000e+00
R69 28 34 1.000000e+00
R70 29 32 1.000000e+00
R71 29 34 1.000000e+00
R72 30 33 1.000000e+00
R73 30 34 1.000000e+00
R74 31 33 1.000000e+00
R75 31 34 1.000000e+00
R76 32 33 1.000000e+00
R77 32 34 1.000000e+00
R78 33 34 1.000000e+00
.end
